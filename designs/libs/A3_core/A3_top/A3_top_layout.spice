* NGSPICE file created from A3_top.ext - technology: gf180mcuD

.subckt gf180mcu_fd_sc_mcu9t5v0__tieh$2 VDD VSS Z VNW VPW
X0 Z a_125_157# VDD VNW pfet_05v0 ad=0.396p pd=2.68u as=0.396p ps=2.68u w=0.9u l=0.5u
X1 a_125_157# a_125_157# VSS VPW nfet_05v0 ad=0.2904p pd=2.2u as=0.2904p ps=2.2u w=0.66u l=0.6u
.ends

.subckt gf180mcu_fd_sc_mcu9t5v0__tiel$3 VDD VSS ZN VNW VPW
X0 ZN a_124_157# VSS VPW nfet_05v0 ad=0.2904p pd=2.2u as=0.2904p ps=2.2u w=0.66u l=0.6u
X1 a_124_157# a_124_157# VDD VNW pfet_05v0 ad=0.396p pd=2.68u as=0.396p ps=2.68u w=0.9u l=0.5u
.ends

.subckt sc_tieh_tiel$1 VDD tieH tieL VSS
Xgf180mcu_fd_sc_mcu9t5v0__tieh$2_0 VDD VSS tieH VDD VSS gf180mcu_fd_sc_mcu9t5v0__tieh$2
Xgf180mcu_fd_sc_mcu9t5v0__tiel$3_0 VDD VSS tieL VDD VSS gf180mcu_fd_sc_mcu9t5v0__tiel$3
.ends

.subckt ppolyf_u_9H3LNU$2 a_n224793_504053# w_n225009_503837# a_n224793_506155#
X0 a_n224793_506155# a_n224793_504053# w_n225009_503837# ppolyf_u r_width=40u r_length=10u
.ends

.subckt diode_nd2ps_06v0_MV3SZ3$2 a_505271_219793# a_503039_219793# a_507503_219793#
+ a_500807_219793# a_500655_219641#
D0 a_500655_219641# a_503039_219793# diode_nd2ps_06v0 pj=40u area=99.99999p
D1 a_500655_219641# a_507503_219793# diode_nd2ps_06v0 pj=40u area=99.99999p
D2 a_500655_219641# a_505271_219793# diode_nd2ps_06v0 pj=40u area=99.99999p
D3 a_500655_219641# a_500807_219793# diode_nd2ps_06v0 pj=40u area=99.99999p
.ends

.subckt diode_pd2nw_06v0_5DG9HC$2 a_507479_219793# a_500831_219793# w_500655_219617#
+ a_503047_219793# a_505263_219793#
D0 a_500831_219793# w_500655_219617# diode_pd2nw_06v0 pj=40u area=99.99999p
D1 a_507479_219793# w_500655_219617# diode_pd2nw_06v0 pj=40u area=99.99999p
D2 a_503047_219793# w_500655_219617# diode_pd2nw_06v0 pj=40u area=99.99999p
D3 a_505263_219793# w_500655_219617# diode_pd2nw_06v0 pj=40u area=99.99999p
.ends

.subckt io_secondary_5p0$1 m1_499212_228525# m1_497955_232243# m1_512035_219553# VSUBS
Xppolyf_u_9H3LNU_0 m1_499212_228525# m1_497955_232243# m1_512035_219553# ppolyf_u_9H3LNU$2
Xdiode_nd2ps_06v0_MV3SZ3_0 m1_499212_228525# m1_499212_228525# m1_499212_228525# m1_499212_228525#
+ VSUBS diode_nd2ps_06v0_MV3SZ3$2
Xdiode_pd2nw_06v0_5DG9HC_0 m1_499212_228525# m1_499212_228525# m1_497955_232243# m1_499212_228525#
+ m1_499212_228525# diode_pd2nw_06v0_5DG9HC$2
.ends

.subckt M a_408568_255933# a_365828_259091# a_411044_251737# a_409618_256263# a_404831_244568#
+ a_401271_243528# a_409818_256643# a_365828_265695# a_376520_259212# a_395682_259299#
+ a_411044_242557# w_364522_258756#
X0 w_364522_258756# w_364522_258756# w_364522_258756# w_364522_258756# pfet_03v3 ad=5.8p pd=21.16u as=0.4068n ps=1.46136m w=10u l=2u M=18
X1 a_365708_259299# a_365708_259299# w_364522_258756# w_364522_258756# pfet_03v3 ad=6p pd=21.2u as=6p ps=21.2u w=10u l=2u M=10
X2 a_402461_244568# a_401271_243528# a_401941_244568# w_364522_258756# pfet_03v3 ad=6p pd=21.2u as=6p ps=21.2u w=10u l=2u
X3 a_404311_244568# a_401151_244568# w_364522_258756# w_364522_258756# pfet_03v3 ad=6p pd=21.2u as=6p ps=21.2u w=10u l=2u
X4 a_374398_259299# a_365828_259091# a_373878_259299# w_364522_258756# pfet_03v3 ad=6p pd=21.2u as=6p ps=21.2u w=10u l=2u
X5 a_386992_259299# a_386992_259299# w_364522_258756# w_364522_258756# pfet_03v3 ad=6p pd=21.2u as=6p ps=21.2u w=10u l=2u M=10
X6 a_383940_262205# a_383940_262205# a_386992_259299# w_364522_258756# pfet_03v3 ad=6p pd=21.2u as=6p ps=21.2u w=10u l=2u M=10
X7 a_401151_244568# a_401151_244568# w_364522_258756# w_364522_258756# pfet_03v3 ad=6p pd=21.2u as=6p ps=21.2u w=10u l=2u
X8 a_404041_244568# a_409618_256263# a_409618_260539# a_376520_259212# nfet_03v3 ad=2.4p pd=9.2u as=2.4p ps=9.2u w=4u l=1u M=2
X9 a_376520_259212# a_376520_259212# a_376520_259212# a_376520_259212# nfet_03v3 ad=4.64p pd=17.16u as=0.1744n ps=0.65672m w=8u l=1u M=4
X10 a_376520_259212# a_376520_259212# a_376520_259212# a_376520_259212# nfet_03v3 ad=2.32p pd=9.16u as=0 ps=0 w=4u l=1u M=12
X11 a_365828_259091# a_365828_259091# a_365708_259299# w_364522_258756# pfet_03v3 ad=6p pd=21.2u as=6p ps=21.2u w=10u l=2u M=10
X12 a_409618_256263# a_409618_260539# a_376520_259212# a_376520_259212# nfet_03v3 ad=2.4p pd=9.2u as=2.4p ps=9.2u w=4u l=1u M=2
X13 a_409618_256263# a_409498_256643# a_376520_259212# a_376520_259212# nfet_03v3 ad=2.4p pd=9.2u as=2.4p ps=9.2u w=4u l=1u M=2
X14 a_377450_262205# a_377450_262205# a_376520_259212# a_376520_259212# nfet_03v3 ad=4.8p pd=17.2u as=4.8p ps=17.2u w=8u l=1u M=10
X15 a_401151_244568# a_365828_265695# w_364522_258756# w_364522_258756# pfet_03v3 ad=6p pd=21.2u as=6p ps=21.2u w=10u l=2u M=4
X16 a_374398_259299# a_374398_259299# a_377450_262205# a_376520_259212# nfet_03v3 ad=4.8p pd=17.2u as=4.8p ps=17.2u w=8u l=1u M=10
X17 a_404041_244568# a_401271_243528# a_403521_244568# w_364522_258756# pfet_03v3 ad=6p pd=21.2u as=6p ps=21.2u w=10u l=2u
X18 a_395162_259299# a_386992_259299# w_364522_258756# w_364522_258756# pfet_03v3 ad=6p pd=21.2u as=6p ps=21.2u w=10u l=2u
X19 a_402731_244568# a_401151_244568# w_364522_258756# w_364522_258756# pfet_03v3 ad=6p pd=21.2u as=6p ps=21.2u w=10u l=2u
X20 a_365708_259299# a_365828_265695# w_364522_258756# w_364522_258756# pfet_03v3 ad=6p pd=21.2u as=6p ps=21.2u w=10u l=2u
X21 a_409498_256643# a_404041_244568# a_376520_259212# a_376520_259212# nfet_03v3 ad=2.4p pd=9.2u as=2.4p ps=9.2u w=4u l=1u M=2
X22 a_395682_259299# a_383940_262205# a_395162_259299# w_364522_258756# pfet_03v3 ad=6p pd=21.2u as=6p ps=21.2u w=10u l=2u
X23 a_409618_260539# a_404041_244568# a_376520_259212# a_376520_259212# nfet_03v3 ad=2.4p pd=9.2u as=2.4p ps=9.2u w=4u l=1u M=2
X24 a_401941_244568# a_401151_244568# w_364522_258756# w_364522_258756# pfet_03v3 ad=6p pd=21.2u as=6p ps=21.2u w=10u l=2u
X25 a_411044_242557# a_402461_244568# a_376520_259212# a_376520_259212# nfet_03v3 ad=2.4p pd=9.2u as=2.4p ps=9.2u w=4u l=1u
X26 a_402461_244568# a_402461_244568# a_376520_259212# a_376520_259212# nfet_03v3 ad=2.4p pd=9.2u as=2.4p ps=9.2u w=4u l=1u
X27 a_404831_244568# a_401271_243528# a_404311_244568# w_364522_258756# pfet_03v3 ad=6p pd=21.2u as=6p ps=21.2u w=10u l=2u
X28 a_401271_243528# a_401271_243528# a_401151_244568# w_364522_258756# pfet_03v3 ad=6p pd=21.2u as=6p ps=21.2u w=10u l=2u
X29 a_403521_244568# a_401151_244568# w_364522_258756# w_364522_258756# pfet_03v3 ad=6p pd=21.2u as=6p ps=21.2u w=10u l=2u
X30 a_410724_251737# a_410134_251737# a_376520_259212# a_376520_259212# nfet_03v3 ad=2.4p pd=9.2u as=2.4p ps=9.2u w=4u l=1u
X31 a_411044_251737# a_403251_244568# a_410724_251737# a_376520_259212# nfet_03v3 ad=2.4p pd=9.2u as=2.4p ps=9.2u w=4u l=1u
X32 a_409818_256643# a_409618_256263# a_409498_256643# a_376520_259212# nfet_03v3 ad=2.4p pd=9.2u as=2.4p ps=9.2u w=4u l=1u M=2
X33 a_386992_259299# a_365828_265695# w_364522_258756# w_364522_258756# pfet_03v3 ad=6p pd=21.2u as=6p ps=21.2u w=10u l=2u
X34 a_410134_251737# a_410134_251737# a_376520_259212# a_376520_259212# nfet_03v3 ad=2.4p pd=9.2u as=2.4p ps=9.2u w=4u l=1u
X35 a_403251_244568# a_403251_244568# a_410134_251737# a_376520_259212# nfet_03v3 ad=2.4p pd=9.2u as=2.4p ps=9.2u w=4u l=1u
X36 a_383620_262205# a_377450_262205# a_376520_259212# a_376520_259212# nfet_03v3 ad=4.8p pd=17.2u as=4.8p ps=17.2u w=8u l=1u
X37 a_373878_259299# a_365708_259299# w_364522_258756# w_364522_258756# pfet_03v3 ad=6p pd=21.2u as=6p ps=21.2u w=10u l=2u
X38 a_403251_244568# a_401271_243528# a_402731_244568# w_364522_258756# pfet_03v3 ad=6p pd=21.2u as=6p ps=21.2u w=10u l=2u
X39 a_383940_262205# a_374398_259299# a_383620_262205# a_376520_259212# nfet_03v3 ad=4.8p pd=17.2u as=4.8p ps=17.2u w=8u l=1u
.ends

.subckt A3_top CCM_OUT PU VDD VSS VIN_OUT BCM_OUT VCM_OUT VIN VBIAS EN PD
Xsc_tieh_tiel$1_0 VDD PD PU VSS sc_tieh_tiel$1
Xio_secondary_5p0$1_0 m3_419992_265695# VDD EN VSS io_secondary_5p0$1
XM_0 VSS a_499016_248165# BCM_OUT m4_400150_261569# VIN_OUT a_498947_268180# CCM_OUT
+ m3_419992_265695# VSS m4_400150_261569# VCM_OUT VDD M
D0 a_499016_248165# VDD diode_pd2nw_06v0 pj=40u area=99.99999p
D1 a_499016_248165# VDD diode_pd2nw_06v0 pj=40u area=99.99999p
D2 VSS a_499016_248165# diode_nd2ps_06v0 pj=40u area=99.99999p
D3 a_498947_268180# VDD diode_pd2nw_06v0 pj=40u area=99.99999p
D4 VSS a_498947_268180# diode_nd2ps_06v0 pj=40u area=99.99999p
D5 a_499016_248165# VDD diode_pd2nw_06v0 pj=40u area=99.99999p
D6 a_499016_248165# VDD diode_pd2nw_06v0 pj=40u area=99.99999p
D7 VSS a_498947_268180# diode_nd2ps_06v0 pj=40u area=99.99999p
D8 VSS a_499016_248165# diode_nd2ps_06v0 pj=40u area=99.99999p
D9 VSS a_498947_268180# diode_nd2ps_06v0 pj=40u area=99.99999p
X0 a_499016_248165# VBIAS VDD ppolyf_u r_width=40u r_length=10u
D10 a_498947_268180# VDD diode_pd2nw_06v0 pj=40u area=99.99999p
D11 VSS a_499016_248165# diode_nd2ps_06v0 pj=40u area=99.99999p
D12 a_498947_268180# VDD diode_pd2nw_06v0 pj=40u area=99.99999p
D13 VSS a_498947_268180# diode_nd2ps_06v0 pj=40u area=99.99999p
D14 a_498947_268180# VDD diode_pd2nw_06v0 pj=40u area=99.99999p
D15 VSS a_499016_248165# diode_nd2ps_06v0 pj=40u area=99.99999p
X1 a_498947_268180# VIN VDD ppolyf_u r_width=40u r_length=10u
.ends
